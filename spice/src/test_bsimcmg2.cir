*** Quick BSIM-CMG NMOS Id-Vg test ***

VD dd 0 0.05
VG gg 0 0
VS ss 0 0
VB bb 0 0

.include /home/rylan/projects/sim-lab/osdi_libs/bsimcmg_modelcards/modelcard.nmos

NMN1 dd gg ss bb nmos

.control
dc VG 0 0.9 0.01
let id = i(VD)
print id > idvg_test2.txt
* Print max current
let imax = maximum(id)
print imax
* Try meas with lower threshold
meas dc vth WHEN id=1e-8 CROSS=1
quit
.endc
.end
