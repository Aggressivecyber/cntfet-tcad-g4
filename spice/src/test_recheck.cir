*** Recheck: Does basic NMOS still work? ***

VD dd 0 0.9
VG gg 0 0
VS ss 0 0
VB bb 0 0

.include /home/rylan/projects/sim-lab/osdi_libs/bsimcmg_modelcards/modelcard.nmos

NMN1 dd gg ss bb nmos

.control
dc VG 0 0.9 0.01
let id = -i(VS)
let ion = maximum(mag(id))
print ion
quit
.endc
.end
