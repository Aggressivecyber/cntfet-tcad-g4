*** Quick BSIM-CMG NMOS Id-Vg test ***

VD dd 0 0.05
VG gg 0 0
VS ss 0 0
VB bb 0 0

.include /home/rylan/projects/sim-lab/osdi_libs/bsimcmg_modelcards/modelcard.nmos

NMN1 dd gg ss bb nmos

.control
dc VG 0 0.9 0.01
let id = -i(VS)
meas dc vth WHEN id=1e-7 CROSS=1
meas dc ion FIND id AT=0.9
print id > idvg_test.txt
quit
.endc
.end
