*** CMOS Inverter VTC test ***

VIN in 0 0
VDD vdd 0 0.9

.model nmos_inv bsimcmg_va
+ BULKMOD = 1 CGEOMOD = 0 TYPE = 1 GEOMOD = 0
+ GIDLMOD = 1 IGBMOD = 0 IGCMOD = 1 IIMOD = 0
+ NGATE = 0 NQSMOD = 0 RDSMOD = 0 RGATEMOD = 0 RGEOMOD = 0
+ SDTERM = 0 SHMOD = 0
+ AGIDL = 1e-12 AGISL = 1e-12
+ CDSC = 0.01 CDSCD = 0.01
+ CFD = 0.2e-10 CFS = 0.2e-10
+ CGDO = 1e-10 CGSO = 1e-10
+ CTH0 = 0.000001243
+ DELTAVSAT = 0.5 DROUT = 1 DSUB = 0.5
+ DVT0 = 0.05 DVT1 = 0.5
+ EASUB = 4.05 EOT = 1.50e-9 EOTACC = 1e-10 EOTBOX = 1.40e-7
+ EPSROX = 3.9 EPSRSP = 3.9 EPSRSUB = 11.9
+ ETA0 = 0.05 ETAMOB = 2 EU = 1.2
+ FPITCH = 4e-8 HFIN = 3e-8
+ IGT = 2.5 KSATIV = 2
+ LINT = -2e-9 LCDSCD = 5e-5 LCDSCDR = 5e-5
+ MEXP = 4 NBODY = 1e22 NC0SUB = 2.86e25 NI0SUB = 1.1e16 NSD = 2e26
+ PCLM = 0.05 PCLMCV = 0.013 PDIBL1 = 0 PDIBL2 = 0.002
+ PHIG = 4.65 PHIN = 0.05 POXEDGE = 1.1 PQM = 0.66
+ QM0 = 0.001 QMFACTOR = 2.5
+ RDSW = 200 RTH0 = 0.225
+ TBGASUB = 4.73e-4 TBGBSUB = 636
+ TFIN = 1.4e-8 TGIDL = -0.007
+ TNOM = 25 TOXP = 2.1e-9
+ U0 = 0.025 UA = 0.55 UCS = 1
+ VSAT = 80000 WR = 1 WTH0 = 2.6e-7

.model pmos_inv bsimcmg_va
+ BULKMOD = 1 CGEOMOD = 0 TYPE = 0 GEOMOD = 0
+ GIDLMOD = 1 IGBMOD = 0 IGCMOD = 1 IIMOD = 0
+ NGATE = 0 NQSMOD = 0 RDSMOD = 0 RGATEMOD = 0 RGEOMOD = 0
+ SDTERM = 0 SHMOD = 0
+ AGIDL = 2e-12 AGISL = 2e-12
+ CDSC = 0.003469 CDSCD = 0.001486
+ CFD = 0.2e-10 CFS = 0.2e-10
+ CGDO = 1e-10 CGSO = 1e-10
+ CTH0 = 1.243e-6
+ DELTAVSAT = 11.56 DROUT = 4.97 DSUB = 0.5
+ DVT0 = 0.05006 DVT1 = 0.4
+ EASUB = 4.05 EOT = 1.50e-9 EOTACC = 3e-10 EOTBOX = 1.40e-7
+ EPSROX = 3.9 EPSRSP = 3.9 EPSRSUB = 11.9
+ ETA0 = 0.03952 ETAMOB = 4 EU = 0.05
+ FPITCH = 4e-8 HFIN = 3e-8
+ IGT = 3.5 KSATIV = 1.592
+ LINT = -2.5e-9
+ MEXP = 2.491 NBODY = 1e22 NC0SUB = 2.86e25 NI0SUB = 1.1e16 NSD = 2e26
+ PCLM = 0.01 PCLMCV = 0.013 PCLMG = 1
+ PDIBL1 = 800 PDIBL2 = 0.005704
+ PHIG = 4.55 PHIN = 0.05 POXEDGE = 1.152 PQM = 0.66
+ PRT = 0.002477 PTWG = 6.322 PTWGT = 0.0015 PVAG = 200
+ QM0 = 2.183e-12 QMFACTOR = 0
+ RDSW = 190.6 RTH0 = 0.15
+ TBGASUB = 4.73e-4 TBGBSUB = 636
+ TFIN = 1.4e-8 TGIDL = -0.01
+ TNOM = 25 TOXP = 2.1e-9
+ U0 = 0.02935 UA = 1.133 UA1 = 0.00134 UCS = 0.2672
+ UD = 0.0105 VSAT = 48390 WR = 1 WTH0 = 2.6e-7

* NMOS pull-down
MN out in 0 0 nmos_inv
* PMOS pull-up
MP out in vdd vdd pmos_inv

.control
dc VIN 0 0.9 0.002
let vout = v(out)
* Print key points
print vout[0] vout[100] vout[200] vout[300] vout[400] vout[450]
* Find trip point (Vout = Vin = Vdd/2)
let diff = vout - in
meas dc vtrip WHEN diff=0 CROSS=1
* Find gain at trip point
let gain = deriv(vout)
let max_gain = maximum(abs(gain))
print max_gain
write /tmp/vtc_test.txt vout in
quit
.endc
.end
