*** Test X prefix for OSDI ***
VD dd 0 0.9
VG gg 0 0
VS ss 0 0
VB bb 0 0

.include /home/rylan/projects/sim-lab/osdi_libs/bsimcmg_modelcards/modelcard.nmos

X1 dd gg ss bb nmos

.control
dc VG 0 0.9 0.01
let id = -i(VS)
print id[45]
quit
.endc
.end
